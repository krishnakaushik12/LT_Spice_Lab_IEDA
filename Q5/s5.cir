* S5 parametric sweep - nmos0, 65 nm PTM BSIM4
.include 65nm_bulk.pm
.options numdgt=7

* run selection: case 1..42 -> experiment (case-1)//3+1, level low/nominal/high
.step param mode 0 1 1
.step param case 1 42 1
.param exp_id={floor((case-1)/3)+1}
.param lvl={(case-1)-3*floor((case-1)/3)}
.func pick(k,lo,nom,hi) {if(abs(exp_id-k)<0.5, if(lvl<0.5,lo,if(lvl<1.5,nom,hi)), nom)}

* parameters: low / nominal / high (SI units, as in the model card)
.param vth0={pick(1,0.30,0.423,0.55)}
.param toxe={pick(2,1.5n,1.85n,2.5n)}
.param l={pick(3,55n,65n,100n)}
.param xl={pick(4,-35n,-30n,-15n)}
.param lint={pick(5,2n,5.25n,8n)}
.param w={pick(6,0.5u,1u,2u)}
.param wint={pick(7,0,5n,40n)}
.param ndep={pick(8,1.5e18,2.54e18,4e18)}
.param nsd={pick(9,5e19,2e20,5e20)}
.param xj={pick(10,10n,19.6n,30n)}
.param ngate={pick(11,1e19,2e20,1e21)}
.param u0={pick(12,0.03,0.0491,0.07)}
.param vsat={pick(13,8e4,124340,2e5)}
.param rdsw={pick(14,50,165,400)}

* bias: mode 0 = ID-VG at VDS = 0.4 V, mode 1 = ID-VD at VGS = 1.1 V
V3 x 0 0
B1 g 0 V=if(mode<0.5, V(x), 1.1)
B2 d 0 V=if(mode<0.5, 0.4, V(x))
M1 d g 0 0 nmos0 l={l} w={w}

.dc V3 0 1.1 1m
.end
